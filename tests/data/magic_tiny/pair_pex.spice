* NGSPICE file created from pair.ext - technology: sky130A

.subckt pair g out vss
X0 out.t0 a_188_0.t1 vss.t1 vss.t0 sky130_fd_pr__nfet_01v8 ad=0.44 pd=2.88 as=0.44 ps=2.88 w=1 l=0.5
X1 a_188_0.t0 g.t0 vss.t3 vss.t2 sky130_fd_pr__nfet_01v8 ad=0.44 pd=2.88 as=0.44 ps=2.88 w=1 l=0.5
R0 a_188_0.n1 a_188_0.n0 185
R1 a_188_0.n1 a_188_0.n2 185
R2 a_188_0.t0 a_188_0.n1 26.4005
R3 a_188_0.n0 a_188_0.n3 9.3005
R4 a_188_0.n2 a_188_0.n11 9.3005
R5 a_188_0.n0 a_188_0.n2 23.0405
R6 a_188_0.n3 a_188_0.n11 0.173577
R7 a_188_0.n11 a_188_0.n10 0.603865
R8 a_188_0.n10 a_188_0.n9 1.05467
R9 a_188_0.n8 a_188_0.n4 9.3005
R10 a_188_0.n9 a_188_0.n8 0.248096
R11 a_188_0.n4 a_188_0.n7 152
R12 a_188_0.n7 a_188_0.n6 37.1145
R13 a_188_0.t1 a_188_0.n5 48.2005
R14 a_188_0.n6 a_188_0.t1 48.2005
R15 vss.n1 vss.n0 9.3005
R16 vss.n3 vss.n2 9.3005
R17 vss.n11 vss.n4 9.3005
R18 vss vss.n23 0.163
R19 vss.n23 vss.n3 0.145813
R20 vss.n3 vss.n11 0.5005
R21 vss.n11 vss.n17 0.292688
R22 vss.n17 vss.n1 0.208313
R23 vss.n19 vss.n18 9.3005
R24 vss.n22 vss.n20 9.3005
R25 vss.n23 vss.n22 0.618288
R26 vss.n22 vss.n19 0.173577
R27 vss.n21 vss.n18 185
R28 vss.n20 vss.n21 185
R29 vss.n20 vss.n18 23.0405
R30 vss.n21 vss.t3 26.4005
R31 vss.n13 vss.n12 9.3005
R32 vss.n16 vss.n14 9.3005
R33 vss.n17 vss.n13 0.618288
R34 vss.n13 vss.n16 0.173577
R35 vss.n12 vss.n15 185
R36 vss.n15 vss.n14 185
R37 vss.n12 vss.n14 23.0405
R38 vss.n15 vss.t1 26.4005
R39 vss.n6 vss.n5 585
R40 vss.n0 vss.n6 585
R41 vss.n8 vss.n7 585
R42 vss.n4 vss.n8 585
R43 vss.n10 vss.n9 585
R44 vss.n2 vss.n10 585
R45 vss.n2 vss.n4 68.2672
R46 vss.n4 vss.n0 68.2672
R47 vss.n10 vss.n8 1050.67
R48 vss.n8 vss.n6 1050.67
R49 vss.n9 vss.t2 4.91121
R50 vss.t2 vss.n7 1566.52
R51 vss.n7 vss.t0 1379.91
R52 vss.n5 vss.t0 191.518
R53 out.n1 out.n0 9.3005
R54 out.n4 out.n2 9.3005
R55 out.n1 out.n4 0.173577
R56 out out.n1 1.03656
R57 out.n0 out.n3 185
R58 out.n3 out.n2 185
R59 out.n2 out.n0 23.0405
R60 out.n3 out.t0 26.4005
R61 g.n3 g.n2 152
R62 g g.n3 0.2005
R63 g.n2 g.n1 37.1145
R64 g.t0 g.n0 48.2005
R65 g.n1 g.t0 48.2005
C0 out vss 0.3109f
C1 g vss 0.30459f
.ends
