* loadrail testbench, cc: the CC netlist: devices on an ideal rail
.include models.sp
.include cc.sp
VDD vdd 0 DC 1.8
* staggered gate pulses (2 ns flat, 0.1 ns ramps, one sink after another): each
* sink conducts while its gate is above vto = 0.5 V, about 2.1 ns in every 10 ns
VG0 g0 0 PULSE(0 1 0n 0.1n 0.1n 2n 10n)
VG1 g1 0 PULSE(0 1 2.5n 0.1n 0.1n 2n 10n)
VG2 g2 0 PULSE(0 1 5n 0.1n 0.1n 2n 10n)
VG3 g3 0 PULSE(0 1 7.5n 0.1n 0.1n 2n 10n)
XI0 vdd 0 g0 g1 g2 g3 loadrail
.tran 10p 40n 0 10p
.end
